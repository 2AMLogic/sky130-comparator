* comparator-decision input-referred noise (reduced sub-model of the INTEGRATION phase: tail + input pair, with the DI-node precharge PMOS pair diode-connected (self-biased) as the loads on the input pair's own drain nodes DIP/DIN, and the cross-coupled latch pairs omitted because they are off (Vgs ~ 0) until regeneration begins; CLK held at VDD (steady evaluate bias, tail on); noise taken at v(DIP,DIN)) corner=tt temp=27.0C supply=1.8V (issue #9)
.lib /Users/rwalters/.volare/sky130A/libs.tech/combined/sky130.lib.spice tt
.temp 27.0
.param vdd_val = 1.8

Vdd VDD 0 dc {vdd_val}
Vclkfix CLK 0 dc {vdd_val}
Vinp VINP 0 dc 0.9 AC 1
Vinn VINN 0 dc 0.9

XM_TAIL TAIL CLK GND GND sky130_fd_pr__nfet_01v8 L=0.5 W=20 nf=1 ad=5.8 as=5.8 pd=40.58 ps=40.58 nrd=0.0145 nrs=0.0145 sa=0 sb=0 sd=0 mult=1 m=1
XM_INN DIP VINN TAIL GND sky130_fd_pr__nfet_01v8 L=0.5 W=10 nf=1 ad=2.9 as=2.9 pd=20.58 ps=20.58 nrd=0.029 nrs=0.029 sa=0 sb=0 sd=0 mult=1 m=1
XM_INP DIN VINP TAIL GND sky130_fd_pr__nfet_01v8 L=0.5 W=10 nf=1 ad=2.9 as=2.9 pd=20.58 ps=20.58 nrd=0.029 nrs=0.029 sa=0 sb=0 sd=0 mult=1 m=1
XM_RST_DIP DIP DIP VDD VDD sky130_fd_pr__pfet_01v8 L=0.5 W=6 nf=1 ad=1.74 as=1.74 pd=12.58 ps=12.58 nrd=0.0483333333333333 nrs=0.0483333333333333 sa=0 sb=0 sd=0 mult=1 m=1
XM_RST_DIN DIN DIN VDD VDD sky130_fd_pr__pfet_01v8 L=0.5 W=6 nf=1 ad=1.74 as=1.74 pd=12.58 ps=12.58 nrd=0.0483333333333333 nrs=0.0483333333333333 sa=0 sb=0 sd=0 mult=1 m=1

.control
option sparse
op
print v(TAIL) v(DIP) v(DIN)
noise v(dip,din) Vinp dec 20 1000 1e+09 20
print inoise_total onoise_total
.endc
.end
