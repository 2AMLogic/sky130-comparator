* extracted by klt extract --deck sky130
* parasitic model (--parasitics):
* - capacitance: net-to-ground for every net's own (non-coupled) area/perimeter, plus net-to-net for the vertical-overlap coupling `coupling` describes below -- a coupled net pair gets a direct capacitor between their two hub nodes, not just capacitors to the deck's ground/substrate net
* - coupling: vertical overlap (crossover) unconditionally -- where one net's conductor on an adjacent metal level sits directly over another *distinct* net's conductor, that overlap area is charged between the two nets instead of to ground (issue #760) -- plus lateral (same-layer, sidewall) coupling, but only for a net pair naming one of the caller's declared `--critical-net` nets (issue #976): facing-edge length within that layer's own minimum-spacing lookback is charged between the two nets, *additively* (not deducted from either net's substrate fringe term, unlike the vertical case -- a known simplification). Any same-layer pair with neither side named `--critical-net`, and fringe shielding in general, are still not modelled
* - resistance: single lumped series resistance per net, distributed as a star across that net's device terminals (issue #592) -- not a per-segment, distributed RC ladder, *unless* `--distributed-rc` names this net via `--critical-net` (issue #977, Epic #709 Phase 2b): then the net's terminals are ordered along their approximate physical spread and its total R/C is broken into a chain of per-segment resistors (segment length proportional to inter-terminal distance) with a ground capacitor at each terminal node (proportional to its adjacent segment length/2), instead of one star hub -- still an approximation (terminal position is a device-placement proxy, not true per-segment routing geometry), but a strictly finer-grained one than the single-hub star
* - frequency: quasi-static -- one frequency-independent R and C per net; no skin effect, no distributed transmission-line behavior
* - substrate tie: 1e+12 ohm to ground -- the substrate is capacitively floating in transient analysis (DC reference only); see --substrate-tie-ohms
.GLOBAL vsubs

* cell gen_compose_0
* pin CLK
* pin GND
* pin OUTN
* pin OUTP
* pin VDD
* pin VINN
* pin VINP
.SUBCKT gen_compose_0 CLK GND OUTN OUTP VDD VINN VINP
* device instance $1 r0 *1 6.17,40.99 nfet
X$1 \$5__t2 VINN__t0 \$7__t0 GND__t11 sky130_fd_pr__nfet_01v8 L=0.5 W=6.5
+ AS=2.73 AD=2.73 PS=13.84 PD=13.84
* device instance $2 r0 *1 7.91,40.99 nfet
X$2 \$9__t2 VINP__t1 \$7__t4 GND__t12 sky130_fd_pr__nfet_01v8 L=0.5 W=6.5
+ AS=2.73 AD=2.73 PS=13.84 PD=13.84
* device instance $3 r0 *1 11.67,40.24 nfet
X$3 OUTP__t3 \$9__t4 \$6__t2 GND__t15 sky130_fd_pr__nfet_01v8 L=0.5 W=8 AS=3.36
+ AD=3.36 PS=16.84 PD=16.84
* device instance $4 r0 *1 30.67,24.24 nfet
X$4 GND__t6 \$9__t3 GND__t7 GND__t18 sky130_fd_pr__nfet_01v8 L=0.5 W=40 AS=16.8
+ AD=16.8 PS=80.84 PD=80.84
* device instance $5 r0 *1 2.67,45 nfet
X$5 \$7__t1 VDD__t0 GND__t4 GND__t20 sky130_fd_pr__nfet_01v8 L=0.5 W=0.8
+ AS=0.336 AD=0.336 PS=2.44 PD=2.44
* device instance $6 r0 *1 15.67,45 nfet
X$6 \$6__t0 \$3__t0 GND__t5 GND__t16 sky130_fd_pr__nfet_01v8 L=0.5 W=8 AS=3.36
+ AD=3.36 PS=16.84 PD=16.84
* device instance $7 r0 *1 6.17,49.01 nfet
X$7 \$9__t1 VINP__t0 \$7__t3 GND__t13 sky130_fd_pr__nfet_01v8 L=0.5 W=6.5
+ AS=2.73 AD=2.73 PS=13.84 PD=13.84
* device instance $8 r0 *1 7.91,49.01 nfet
X$8 \$5__t3 VINN__t1 \$7__t2 GND__t14 sky130_fd_pr__nfet_01v8 L=0.5 W=6.5
+ AS=2.73 AD=2.73 PS=13.84 PD=13.84
* device instance $9 r0 *1 11.67,49.76 nfet
X$9 OUTN__t0 \$5__t4 \$6__t1 GND__t17 sky130_fd_pr__nfet_01v8 L=0.5 W=8 AS=3.36
+ AD=3.36 PS=16.84 PD=16.84
* device instance $10 r0 *1 34.67,45 nfet
X$10 GND__t3 \$3__t1 GND__t2 GND__t21 sky130_fd_pr__nfet_01v8 L=0.5 W=20 AS=8.4
+ AD=8.4 PS=40.84 PD=40.84
* device instance $11 r0 *1 30.67,65.76 nfet
X$11 GND__t1 \$5__t0 GND__t0 GND__t19 sky130_fd_pr__nfet_01v8 L=0.5 W=40
+ AS=16.8 AD=16.8 PS=80.84 PD=80.84
* device instance $12 r0 *1 19.17,36.24 pfet
X$12 OUTP__t0 OUTN__t1 VDD__t1 VDD__t2 sky130_fd_pr__pfet_01v8 L=0.5 W=16
+ AS=6.72 AD=6.72 PS=32.84 PD=32.84
* device instance $13 r0 *1 23.17,40.24 pfet
X$13 OUTP__t1 \$3__t2 VDD__t3 VDD__t4 sky130_fd_pr__pfet_01v8 L=0.5 W=8 AS=3.36
+ AD=3.36 PS=16.84 PD=16.84
* device instance $14 r0 *1 23.17,49.76 pfet
X$14 OUTN__t2 \$3__t4 VDD__t6 VDD__t5 sky130_fd_pr__pfet_01v8 L=0.5 W=8 AS=3.36
+ AD=3.36 PS=16.84 PD=16.84
* device instance $15 r0 *1 19.17,53.76 pfet
X$15 OUTN__t3 OUTP__t2 VDD__t8 VDD__t7 sky130_fd_pr__pfet_01v8 L=0.5 W=16
+ AS=6.72 AD=6.72 PS=32.84 PD=32.84
* device instance $16 r0 *1 39.265,45 res_high_po
X$16 \$3__t3 CLK__t0 GND__t8 sky130_fd_pr__res_high_po l=1.75 w=0.35
* device instance $17 r0 *1 16.89,65.175 res_high_po
X$17 \$5__t1 VDD__t9 GND__t9 sky130_fd_pr__res_high_po l=22 w=0.35
* device instance $18 r0 *1 16.89,67.775 res_high_po
X$18 VDD__t10 \$9__t0 GND__t10 sky130_fd_pr__res_high_po l=22 w=0.35
* device instance _3_t0 r0 *1 0,0
R_3_t0 \$3__t0 \$3 357.328511994
* device instance _3_t1 r0 *1 0,0
R_3_t1 \$3__t1 \$3 232.066550762
* device instance _3_t2 r0 *1 0,0
R_3_t2 \$3__t2 \$3 193.252221837
* device instance _3_t3 r0 *1 0,0
R_3_t3 \$3__t3 \$3 374.607093571
* device instance _3_t4 r0 *1 0,0
R_3_t4 \$3__t4 \$3 193.252221837
* device instance _3 r0 *1 0,0
C_3 \$3 vsubs 1.0238036e-14
* device instance _5_t0 r0 *1 0,0
R_5_t0 \$5__t0 \$5 368.31199137
* device instance _5_t1 r0 *1 0,0
R_5_t1 \$5__t1 \$5 209.626090269
* device instance _5_t2 r0 *1 0,0
R_5_t2 \$5__t2 \$5 291.441248511
* device instance _5_t3 r0 *1 0,0
R_5_t3 \$5__t3 \$5 157.87438835
* device instance _5_t4 r0 *1 0,0
R_5_t4 \$5__t4 \$5 98.7474814997
* device instance _5 r0 *1 0,0
C_5 \$5 vsubs 9.906148e-15
* device instance _6_t0 r0 *1 0,0
R_6_t0 \$6__t0 \$6 156.787929129
* device instance _6_t1 r0 *1 0,0
R_6_t1 \$6__t1 \$6 290.638685436
* device instance _6_t2 r0 *1 0,0
R_6_t2 \$6__t2 \$6 290.638685436
* device instance _6 r0 *1 0,0
C_6 \$6 vsubs 3.954834e-15
* device instance _7_t0 r0 *1 0,0
R_7_t0 \$7__t0 \$7 163.066947164
* device instance _7_t1 r0 *1 0,0
R_7_t1 \$7__t1 \$7 142.165028345
* device instance _7_t2 r0 *1 0,0
R_7_t2 \$7__t2 \$7 177.821338664
* device instance _7_t3 r0 *1 0,0
R_7_t3 \$7__t3 \$7 163.066947164
* device instance _7_t4 r0 *1 0,0
R_7_t4 \$7__t4 \$7 177.821338664
* device instance _7 r0 *1 0,0
C_7 \$7 vsubs 4.439873e-15
* device instance _9_t0 r0 *1 0,0
R_9_t0 \$9__t0 \$9 367.528678743
* device instance _9_t1 r0 *1 0,0
R_9_t1 \$9__t1 \$9 151.189006278
* device instance _9_t2 r0 *1 0,0
R_9_t2 \$9__t2 \$9 119.016293686
* device instance _9_t3 r0 *1 0,0
R_9_t3 \$9__t3 \$9 404.428594399
* device instance _9_t4 r0 *1 0,0
R_9_t4 \$9__t4 \$9 81.0300268944
* device instance _9 r0 *1 0,0
C_9 \$9 vsubs 9.303445e-15
* device instance CLK_t0 r0 *1 0,0
RCLK_t0 CLK__t0 CLK 82.154
* device instance CLK r0 *1 0,0
CCLK CLK vsubs 9.89517e-16
* device instance GND_t0 r0 *1 0,0
RGND_t0 GND__t0 GND 386.60191507
* device instance GND_t1 r0 *1 0,0
RGND_t1 GND__t1 GND 386.60191507
* device instance GND_t2 r0 *1 0,0
RGND_t2 GND__t2 GND 259.593967468
* device instance GND_t3 r0 *1 0,0
RGND_t3 GND__t3 GND 259.593967468
* device instance GND_t4 r0 *1 0,0
RGND_t4 GND__t4 GND 322.320644719
* device instance GND_t5 r0 *1 0,0
RGND_t5 GND__t5 GND 92.7048430922
* device instance GND_t6 r0 *1 0,0
RGND_t6 GND__t6 GND 449.750397189
* device instance GND_t7 r0 *1 0,0
RGND_t7 GND__t7 GND 449.750397189
* device instance GND_t8 r0 *1 0,0
RGND_t8 GND__t8 GND 341.948592915
* device instance GND_t9 r0 *1 0,0
RGND_t9 GND__t9 GND 335.025531751
* device instance GND_t10 r0 *1 0,0
RGND_t10 GND__t10 GND 381.201646053
* device instance GND_t11 r0 *1 0,0
RGND_t11 GND__t11 GND 278.820863241
* device instance GND_t12 r0 *1 0,0
RGND_t12 GND__t12 GND 250.142368513
* device instance GND_t13 r0 *1 0,0
RGND_t13 GND__t13 GND 259.883536213
* device instance GND_t14 r0 *1 0,0
RGND_t14 GND__t14 GND 228.844014868
* device instance GND_t15 r0 *1 0,0
RGND_t15 GND__t15 GND 199.058537964
* device instance GND_t16 r0 *1 0,0
RGND_t16 GND__t16 GND 92.7048430922
* device instance GND_t17 r0 *1 0,0
RGND_t17 GND__t17 GND 165.875393678
* device instance GND_t18 r0 *1 0,0
RGND_t18 GND__t18 GND 449.750397189
* device instance GND_t19 r0 *1 0,0
RGND_t19 GND__t19 GND 386.60191507
* device instance GND_t20 r0 *1 0,0
RGND_t20 GND__t20 GND 322.320644719
* device instance GND_t21 r0 *1 0,0
RGND_t21 GND__t21 GND 259.593967468
* device instance GND r0 *1 0,0
CGND GND vsubs 3.5731335e-14
* device instance OUTN_t0 r0 *1 0,0
ROUTN_t0 OUTN__t0 OUTN 309.428769076
* device instance OUTN_t1 r0 *1 0,0
ROUTN_t1 OUTN__t1 OUTN 491.176513372
* device instance OUTN_t2 r0 *1 0,0
ROUTN_t2 OUTN__t2 OUTN 238.458141823
* device instance OUTN_t3 r0 *1 0,0
ROUTN_t3 OUTN__t3 OUTN 283.063575729
* device instance OUTN r0 *1 0,0
COUTN OUTN vsubs 1.1879141e-14
* device instance OUTP_t0 r0 *1 0,0
ROUTP_t0 OUTP__t0 OUTP 282.687235821
* device instance OUTP_t1 r0 *1 0,0
ROUTP_t1 OUTP__t1 OUTP 238.141105924
* device instance OUTP_t2 r0 *1 0,0
ROUTP_t2 OUTP__t2 OUTP 490.523482253
* device instance OUTP_t3 r0 *1 0,0
ROUTP_t3 OUTP__t3 OUTP 309.017376002
* device instance OUTP r0 *1 0,0
COUTP OUTP vsubs 1.1510864e-14
* device instance VDD_t0 r0 *1 0,0
RVDD_t0 VDD__t0 VDD 303.781680537
* device instance VDD_t1 r0 *1 0,0
RVDD_t1 VDD__t1 VDD 233.202202892
* device instance VDD_t2 r0 *1 0,0
RVDD_t2 VDD__t2 VDD 233.202202892
* device instance VDD_t3 r0 *1 0,0
RVDD_t3 VDD__t3 VDD 179.324945069
* device instance VDD_t4 r0 *1 0,0
RVDD_t4 VDD__t4 VDD 179.324945069
* device instance VDD_t5 r0 *1 0,0
RVDD_t5 VDD__t5 VDD 83.5674040422
* device instance VDD_t6 r0 *1 0,0
RVDD_t6 VDD__t6 VDD 83.5674040422
* device instance VDD_t7 r0 *1 0,0
RVDD_t7 VDD__t7 VDD 89.7484472491
* device instance VDD_t8 r0 *1 0,0
RVDD_t8 VDD__t8 VDD 89.7484472491
* device instance VDD_t9 r0 *1 0,0
RVDD_t9 VDD__t9 VDD 301.270515864
* device instance VDD_t10 r0 *1 0,0
RVDD_t10 VDD__t10 VDD 348.858805095
* device instance VDD r0 *1 0,0
CVDD VDD vsubs 2.1137727e-14
* device instance VINN_t0 r0 *1 0,0
RVINN_t0 VINN__t0 VINN 311.03935
* device instance VINN_t1 r0 *1 0,0
RVINN_t1 VINN__t1 VINN 311.03935
* device instance VINN r0 *1 0,0
CVINN VINN vsubs 2.036445e-15
* device instance VINP_t0 r0 *1 0,0
RVINP_t0 VINP__t0 VINP 310.7034
* device instance VINP_t1 r0 *1 0,0
RVINP_t1 VINP__t1 VINP 310.7034
* device instance VINP r0 *1 0,0
CVINP VINP vsubs 1.88884e-15
* device instance cc__3_GND r0 *1 0,0
Ccc__3_GND \$3 GND 7.1819e-17
* device instance cc__3_OUTN r0 *1 0,0
Ccc__3_OUTN \$3 OUTN 2.7415e-17
* device instance cc__3_OUTP r0 *1 0,0
Ccc__3_OUTP \$3 OUTP 4.2763e-17
* device instance cc__3_VDD r0 *1 0,0
Ccc__3_VDD \$3 VDD 2.3059e-17
* device instance cc__5__7 r0 *1 0,0
Ccc__5__7 \$5 \$7 3.0697e-17
* device instance cc__5__9 r0 *1 0,0
Ccc__5__9 \$5 \$9 8.5526e-17
* device instance cc__5_OUTN r0 *1 0,0
Ccc__5_OUTN \$5 OUTN 1.5348e-17
* device instance cc__5_OUTP r0 *1 0,0
Ccc__5_OUTP \$5 OUTP 1.3707e-17
* device instance cc__5_VDD r0 *1 0,0
Ccc__5_VDD \$5 VDD 5.647e-17
* device instance cc__5_VINP r0 *1 0,0
Ccc__5_VINP \$5 VINP 2.9056e-17
* device instance cc__6_GND r0 *1 0,0
Ccc__6_GND \$6 GND 3.0697e-17
* device instance cc__6_OUTN r0 *1 0,0
Ccc__6_OUTN \$6 OUTN 2.9056e-17
* device instance cc__6_OUTP r0 *1 0,0
Ccc__6_OUTP \$6 OUTP 1.5348e-17
* device instance cc__7__9 r0 *1 0,0
Ccc__7__9 \$7 \$9 3.0697e-17
* device instance cc__7_VINN r0 *1 0,0
Ccc__7_VINN \$7 VINN 2.7415e-17
* device instance cc__7_VINP r0 *1 0,0
Ccc__7_VINP \$7 VINP 1.5348e-17
* device instance cc__9_VDD r0 *1 0,0
Ccc__9_VDD \$9 VDD 4.1122e-17
* device instance cc__9_VINP r0 *1 0,0
Ccc__9_VINP \$9 VINP 2.9056e-17
* device instance cc_GND_OUTN r0 *1 0,0
Ccc_GND_OUTN GND OUTN 1.3707e-17
* device instance cc_GND_OUTP r0 *1 0,0
Ccc_GND_OUTP GND OUTP 1.3707e-17
* device instance cc_OUTN_OUTP r0 *1 0,0
Ccc_OUTN_OUTP OUTN OUTP 5.4829e-17
* device instance cc_OUTN_VDD r0 *1 0,0
Ccc_OUTN_VDD OUTN VDD 7.2726e-17
* device instance cc_OUTP_VDD r0 *1 0,0
Ccc_OUTP_VDD OUTP VDD 4.6597e-17
* device instance vsubs_dctie r0 *1 0,0
Rvsubs_dctie vsubs 0 1e+12
.ENDS gen_compose_0
