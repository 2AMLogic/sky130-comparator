* extracted by klt extract --deck sky130
* parasitic model (--parasitics):
* - capacitance: net-to-ground for every net's own (non-coupled) area/perimeter, plus net-to-net for the vertical-overlap coupling `coupling` describes below -- a coupled net pair gets a direct capacitor between their two hub nodes, not just capacitors to the deck's ground/substrate net
* - coupling: vertical overlap (crossover) unconditionally -- where one net's conductor on an adjacent metal level sits directly over another *distinct* net's conductor, that overlap area is charged between the two nets instead of to ground (issue #760) -- plus lateral (same-layer, sidewall) coupling, but only for a net pair naming one of the caller's declared `--critical-net` nets (issue #976): facing-edge length within that layer's own minimum-spacing lookback is charged between the two nets, *additively* (not deducted from either net's substrate fringe term, unlike the vertical case -- a known simplification). Any same-layer pair with neither side named `--critical-net`, and fringe shielding in general, are still not modelled
* - resistance: single lumped series resistance per net, distributed as a star across that net's device terminals (issue #592) -- not a per-segment, distributed RC ladder, *unless* `--distributed-rc` names this net via `--critical-net` (issue #977, Epic #709 Phase 2b): then the net's terminals are ordered along their approximate physical spread and its total R/C is broken into a chain of per-segment resistors (segment length proportional to inter-terminal distance) with a ground capacitor at each terminal node (proportional to its adjacent segment length/2), instead of one star hub -- still an approximation (terminal position is a device-placement proxy, not true per-segment routing geometry), but a strictly finer-grained one than the single-hub star
* - frequency: quasi-static -- one frequency-independent R and C per net; no skin effect, no distributed transmission-line behavior
.GLOBAL vsubs

* cell gen_compose_0
* pin CLK
* pin GND
* pin OUTN
* pin OUTP
* pin VDD
* pin VINN
* pin VINP
.SUBCKT gen_compose_0 CLK GND OUTN OUTP VDD VINN VINP
* device instance $1 r0 *1 6.17,41.14 nfet
X$1 \$10__t1 VINN__t0 \$4__t0 GND__t11 sky130_fd_pr__nfet_01v8 L=0.5 W=6.5
+ AS=2.73 AD=2.73 PS=13.84 PD=13.84
* device instance $2 r0 *1 7.91,41.14 nfet
X$2 \$6__t2 VINP__t0 \$4__t4 GND__t12 sky130_fd_pr__nfet_01v8 L=0.5 W=6.5
+ AS=2.73 AD=2.73 PS=13.84 PD=13.84
* device instance $3 r0 *1 11.67,40.39 nfet
X$3 OUTP__t3 \$6__t4 \$7__t2 GND__t15 sky130_fd_pr__nfet_01v8 L=0.5 W=8 AS=3.36
+ AD=3.36 PS=16.84 PD=16.84
* device instance $4 r0 *1 30.67,24.39 nfet
X$4 GND__t6 \$6__t0 GND__t7 GND__t18 sky130_fd_pr__nfet_01v8 L=0.5 W=40 AS=16.8
+ AD=16.8 PS=80.84 PD=80.84
* device instance $5 r0 *1 2.67,45 nfet
X$5 \$4__t1 VDD__t0 GND__t4 GND__t20 sky130_fd_pr__nfet_01v8 L=0.5 W=0.8
+ AS=0.336 AD=0.336 PS=2.44 PD=2.44
* device instance $6 r0 *1 15.67,45 nfet
X$6 \$7__t0 \$3__t0 GND__t5 GND__t16 sky130_fd_pr__nfet_01v8 L=0.5 W=8 AS=3.36
+ AD=3.36 PS=16.84 PD=16.84
* device instance $7 r0 *1 6.17,48.86 nfet
X$7 \$6__t3 VINP__t1 \$4__t3 GND__t13 sky130_fd_pr__nfet_01v8 L=0.5 W=6.5
+ AS=2.73 AD=2.73 PS=13.84 PD=13.84
* device instance $8 r0 *1 7.91,48.86 nfet
X$8 \$10__t2 VINN__t1 \$4__t2 GND__t14 sky130_fd_pr__nfet_01v8 L=0.5 W=6.5
+ AS=2.73 AD=2.73 PS=13.84 PD=13.84
* device instance $9 r0 *1 11.67,49.61 nfet
X$9 OUTN__t0 \$10__t4 \$7__t1 GND__t17 sky130_fd_pr__nfet_01v8 L=0.5 W=8
+ AS=3.36 AD=3.36 PS=16.84 PD=16.84
* device instance $10 r0 *1 34.67,45 nfet
X$10 GND__t3 \$3__t1 GND__t2 GND__t21 sky130_fd_pr__nfet_01v8 L=0.5 W=20 AS=8.4
+ AD=8.4 PS=40.84 PD=40.84
* device instance $11 r0 *1 30.67,65.61 nfet
X$11 GND__t1 \$10__t3 GND__t0 GND__t19 sky130_fd_pr__nfet_01v8 L=0.5 W=40
+ AS=16.8 AD=16.8 PS=80.84 PD=80.84
* device instance $12 r0 *1 19.17,36.39 pfet
X$12 OUTP__t0 OUTN__t1 VDD__t1 VDD__t2 sky130_fd_pr__pfet_01v8 L=0.5 W=16
+ AS=6.72 AD=6.72 PS=32.84 PD=32.84
* device instance $13 r0 *1 23.17,40.39 pfet
X$13 OUTP__t1 \$3__t2 VDD__t3 VDD__t4 sky130_fd_pr__pfet_01v8 L=0.5 W=8 AS=3.36
+ AD=3.36 PS=16.84 PD=16.84
* device instance $14 r0 *1 23.17,49.61 pfet
X$14 OUTN__t2 \$3__t4 VDD__t7 VDD__t6 sky130_fd_pr__pfet_01v8 L=0.5 W=8 AS=3.36
+ AD=3.36 PS=16.84 PD=16.84
* device instance $15 r0 *1 19.17,53.61 pfet
X$15 OUTN__t3 OUTP__t2 VDD__t9 VDD__t8 sky130_fd_pr__pfet_01v8 L=0.5 W=16
+ AS=6.72 AD=6.72 PS=32.84 PD=32.84
* device instance $16 r0 *1 39.295,45 res_high_po
X$16 \$3__t3 CLK__t0 GND__t8 sky130_fd_pr__res_high_po l=1.75 w=0.42
* device instance $17 r0 *1 16.92,65.21 res_high_po
X$17 \$10__t0 VDD__t10 GND__t9 sky130_fd_pr__res_high_po l=22 w=0.42
* device instance $18 r0 *1 16.92,66.03 res_high_po
X$18 VDD__t5 \$6__t1 GND__t10 sky130_fd_pr__res_high_po l=22 w=0.42
* device instance _10_t0 r0 *1 0,0
R_10_t0 \$10__t0 \$10 132.241972044
* device instance _10_t1 r0 *1 0,0
R_10_t1 \$10__t1 \$10 180.43650231
* device instance _10_t2 r0 *1 0,0
R_10_t2 \$10__t2 \$10 99.5389624445
* device instance _10_t3 r0 *1 0,0
R_10_t3 \$10__t3 \$10 229.766448091
* device instance _10_t4 r0 *1 0,0
R_10_t4 \$10__t4 \$10 62.7703151102
* device instance _10 r0 *1 0,0
C_10 \$10 vsubs 8.98701e-15
* device instance _3_t0 r0 *1 0,0
R_3_t0 \$3__t0 \$3 140.251918756
* device instance _3_t1 r0 *1 0,0
R_3_t1 \$3__t1 \$3 90.9659950281
* device instance _3_t2 r0 *1 0,0
R_3_t2 \$3__t2 \$3 74.4748416138
* device instance _3_t3 r0 *1 0,0
R_3_t3 \$3__t3 \$3 147.249302989
* device instance _3_t4 r0 *1 0,0
R_3_t4 \$3__t4 \$3 74.4748416138
* device instance _3 r0 *1 0,0
C_3 \$3 vsubs 9.151286e-15
* device instance _4_t0 r0 *1 0,0
R_4_t0 \$4__t0 \$4 161.590596814
* device instance _4_t1 r0 *1 0,0
R_4_t1 \$4__t1 \$4 146.352441228
* device instance _4_t2 r0 *1 0,0
R_4_t2 \$4__t2 \$4 177.318282573
* device instance _4_t3 r0 *1 0,0
R_4_t3 \$4__t3 \$4 161.590596814
* device instance _4_t4 r0 *1 0,0
R_4_t4 \$4__t4 \$4 177.318282573
* device instance _4 r0 *1 0,0
C_4 \$4 vsubs 4.373331e-15
* device instance _6_t0 r0 *1 0,0
R_6_t0 \$6__t0 \$6 257.552513267
* device instance _6_t1 r0 *1 0,0
R_6_t1 \$6__t1 \$6 222.594703681
* device instance _6_t2 r0 *1 0,0
R_6_t2 \$6__t2 \$6 74.9578903588
* device instance _6_t3 r0 *1 0,0
R_6_t3 \$6__t3 \$6 98.3198905135
* device instance _6_t4 r0 *1 0,0
R_6_t4 \$6__t4 \$6 48.7875021795
* device instance _6 r0 *1 0,0
C_6 \$6 vsubs 8.461843e-15
* device instance _7_t0 r0 *1 0,0
R_7_t0 \$7__t0 \$7 160.656121868
* device instance _7_t1 r0 *1 0,0
R_7_t1 \$7__t1 \$7 289.117489066
* device instance _7_t2 r0 *1 0,0
R_7_t2 \$7__t2 \$7 289.117489066
* device instance _7 r0 *1 0,0
C_7 \$7 vsubs 4.013191e-15
* device instance CLK_t0 r0 *1 0,0
RCLK_t0 CLK__t0 CLK 62.6625
* device instance CLK r0 *1 0,0
CCLK CLK vsubs 5.85805e-16
* device instance GND_t0 r0 *1 0,0
RGND_t0 GND__t0 GND 388.651539636
* device instance GND_t1 r0 *1 0,0
RGND_t1 GND__t1 GND 388.651539636
* device instance GND_t2 r0 *1 0,0
RGND_t2 GND__t2 GND 261.507374077
* device instance GND_t3 r0 *1 0,0
RGND_t3 GND__t3 GND 261.507374077
* device instance GND_t4 r0 *1 0,0
RGND_t4 GND__t4 GND 324.944251788
* device instance GND_t5 r0 *1 0,0
RGND_t5 GND__t5 GND 93.0224967504
* device instance GND_t6 r0 *1 0,0
RGND_t6 GND__t6 GND 449.713919418
* device instance GND_t7 r0 *1 0,0
RGND_t7 GND__t7 GND 449.713919418
* device instance GND_t8 r0 *1 0,0
RGND_t8 GND__t8 GND 345.14060022
* device instance GND_t9 r0 *1 0,0
RGND_t9 GND__t9 GND 339.758803588
* device instance GND_t10 r0 *1 0,0
RGND_t10 GND__t10 GND 354.429001996
* device instance GND_t11 r0 *1 0,0
RGND_t11 GND__t11 GND 279.652973887
* device instance GND_t12 r0 *1 0,0
RGND_t12 GND__t12 GND 250.551144344
* device instance GND_t13 r0 *1 0,0
RGND_t13 GND__t13 GND 261.95045735
* device instance GND_t14 r0 *1 0,0
RGND_t14 GND__t14 GND 230.625523813
* device instance GND_t15 r0 *1 0,0
RGND_t15 GND__t15 GND 198.29121367
* device instance GND_t16 r0 *1 0,0
RGND_t16 GND__t16 GND 93.0224967504
* device instance GND_t17 r0 *1 0,0
RGND_t17 GND__t17 GND 166.939384665
* device instance GND_t18 r0 *1 0,0
RGND_t18 GND__t18 GND 449.713919418
* device instance GND_t19 r0 *1 0,0
RGND_t19 GND__t19 GND 388.651539636
* device instance GND_t20 r0 *1 0,0
RGND_t20 GND__t20 GND 324.944251788
* device instance GND_t21 r0 *1 0,0
RGND_t21 GND__t21 GND 261.507374077
* device instance GND r0 *1 0,0
CGND GND vsubs 3.5595668e-14
* device instance OUTN_t0 r0 *1 0,0
ROUTN_t0 OUTN__t0 OUTN 265.023762098
* device instance OUTN_t1 r0 *1 0,0
ROUTN_t1 OUTN__t1 OUTN 413.714657114
* device instance OUTN_t2 r0 *1 0,0
ROUTN_t2 OUTN__t2 OUTN 203.738579773
* device instance OUTN_t3 r0 *1 0,0
ROUTN_t3 OUTN__t3 OUTN 240.499201016
* device instance OUTN r0 *1 0,0
COUTN OUTN vsubs 1.1631209e-14
* device instance OUTP_t0 r0 *1 0,0
ROUTP_t0 OUTP__t0 OUTP 240.198474271
* device instance OUTP_t1 r0 *1 0,0
ROUTP_t1 OUTP__t1 OUTP 203.483819508
* device instance OUTP_t2 r0 *1 0,0
ROUTP_t2 OUTP__t2 OUTP 413.197337048
* device instance OUTP_t3 r0 *1 0,0
ROUTP_t3 OUTP__t3 OUTP 264.692369173
* device instance OUTP r0 *1 0,0
COUTP OUTP vsubs 1.1348877e-14
* device instance VDD_t0 r0 *1 0,0
RVDD_t0 VDD__t0 VDD 275.709213265
* device instance VDD_t1 r0 *1 0,0
RVDD_t1 VDD__t1 VDD 206.936252111
* device instance VDD_t2 r0 *1 0,0
RVDD_t2 VDD__t2 VDD 206.936252111
* device instance VDD_t3 r0 *1 0,0
RVDD_t3 VDD__t3 VDD 158.487425575
* device instance VDD_t4 r0 *1 0,0
RVDD_t4 VDD__t4 VDD 158.487425575
* device instance VDD_t5 r0 *1 0,0
RVDD_t5 VDD__t5 VDD 290.706418041
* device instance VDD_t6 r0 *1 0,0
RVDD_t6 VDD__t6 VDD 75.9141772034
* device instance VDD_t7 r0 *1 0,0
RVDD_t7 VDD__t7 VDD 75.9141772034
* device instance VDD_t8 r0 *1 0,0
RVDD_t8 VDD__t8 VDD 81.6891828248
* device instance VDD_t9 r0 *1 0,0
RVDD_t9 VDD__t9 VDD 81.6891828248
* device instance VDD_t10 r0 *1 0,0
RVDD_t10 VDD__t10 VDD 277.062993265
* device instance VDD r0 *1 0,0
CVDD VDD vsubs 2.0145914e-14
* device instance VINN_t0 r0 *1 0,0
RVINN_t0 VINN__t0 VINN 109.4902
* device instance VINN_t1 r0 *1 0,0
RVINN_t1 VINN__t1 VINN 109.4902
* device instance VINN r0 *1 0,0
CVINN VINN vsubs 1.601158e-15
* device instance VINP_t0 r0 *1 0,0
RVINP_t0 VINP__t0 VINP 109.8652
* device instance VINP_t1 r0 *1 0,0
RVINP_t1 VINP__t1 VINP 109.8652
* device instance VINP r0 *1 0,0
CVINP VINP vsubs 1.757421e-15
* device instance cc__10__4 r0 *1 0,0
Ccc__10__4 \$10 \$4 2.8778e-17
* device instance cc__10__6 r0 *1 0,0
Ccc__10__6 \$10 \$6 8.9015e-17
* device instance cc__10_VDD r0 *1 0,0
Ccc__10_VDD \$10 VDD 3.6142e-17
* device instance cc__10_VINP r0 *1 0,0
Ccc__10_VINP \$10 VINP 1.2047e-17
* device instance cc__3_GND r0 *1 0,0
Ccc__3_GND \$3 GND 6.4921e-17
* device instance cc__3_OUTN r0 *1 0,0
Ccc__3_OUTN \$3 OUTN 2.4095e-17
* device instance cc__3_OUTP r0 *1 0,0
Ccc__3_OUTP \$3 OUTP 3.8484e-17
* device instance cc__3_VDD r0 *1 0,0
Ccc__3_VDD \$3 VDD 2.1229e-17
* device instance cc__4__6 r0 *1 0,0
Ccc__4__6 \$4 \$6 2.8778e-17
* device instance cc__4_VINN r0 *1 0,0
Ccc__4_VINN \$4 VINN 4.9036e-17
* device instance cc__6_VDD r0 *1 0,0
Ccc__6_VDD \$6 VDD 3.6142e-17
* device instance cc__6_VINN r0 *1 0,0
Ccc__6_VINN \$6 VINN 1.2471e-17
* device instance cc__6_VINP r0 *1 0,0
Ccc__6_VINP \$6 VINP 1.2047e-17
* device instance cc__7_GND r0 *1 0,0
Ccc__7_GND \$7 GND 2.8778e-17
* device instance cc__7_OUTN r0 *1 0,0
Ccc__7_OUTN \$7 OUTN 3.8484e-17
* device instance cc__7_OUTP r0 *1 0,0
Ccc__7_OUTP \$7 OUTP 2.6437e-17
* device instance cc_GND_OUTN r0 *1 0,0
Ccc_GND_OUTN GND OUTN 1.2047e-17
* device instance cc_GND_OUTP r0 *1 0,0
Ccc_GND_OUTP GND OUTP 1.2047e-17
* device instance cc_OUTN_OUTP r0 *1 0,0
Ccc_OUTN_OUTP OUTN OUTP 4.819e-17
* device instance cc_OUTN_VDD r0 *1 0,0
Ccc_OUTN_VDD OUTN VDD 6.5086e-17
* device instance cc_OUTP_VDD r0 *1 0,0
Ccc_OUTP_VDD OUTP VDD 6.5086e-17
* device instance vsubs_dctie r0 *1 0,0
Rvsubs_dctie vsubs 0 1e+12
.ENDS gen_compose_0
